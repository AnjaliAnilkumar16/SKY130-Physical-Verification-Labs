* NGSPICE file created from sky130_fd_sc_hd__and2_1.ext - technology: sky130A

.subckt sky130_fd_sc_hd__and2_1 VPWR VGND X B A VPB VNB
X0 VPWR B a_59_75# VPB sky130_fd_pr__pfet_01v8_hvt ad=0p pd=0u as=0p ps=0u w=420000u l=150000u
X1 X a_59_75# VPWR VPB sky130_fd_pr__pfet_01v8_hvt ad=0p pd=0u as=0p ps=0u w=1e+06u l=150000u
X2 VGND B a_145_75# VNB sky130_fd_pr__nfet_01v8 ad=0p pd=0u as=0p ps=0u w=420000u l=150000u
X3 a_59_75# A VPWR VPB sky130_fd_pr__pfet_01v8_hvt ad=0p pd=0u as=0p ps=0u w=420000u l=150000u
X4 X a_59_75# VGND VNB sky130_fd_pr__nfet_01v8 ad=0p pd=0u as=0p ps=0u w=650000u l=150000u
X5 a_145_75# A a_59_75# VNB sky130_fd_pr__nfet_01v8 ad=0p pd=0u as=0p ps=0u w=420000u l=150000u
C0 a_59_75# B 0.30fF
C1 VPWR a_59_75# 0.36fF
C2 A X 0.01fF
C3 A VGND 0.02fF
C4 VPWR B 0.01fF
C5 a_59_75# X 0.21fF
C6 a_59_75# VGND 0.20fF
C7 B X 0.01fF
C8 B VGND 0.01fF
C9 a_145_75# a_59_75# 0.02fF
C10 VPWR X 0.22fF
C11 VPWR VGND 0.01fF
C12 A a_59_75# 0.19fF
C13 A B 0.15fF
C14 A VPWR 0.03fF
C15 VPWR VPB 0.03fF
C16 VGND X 0.18fF
.ends
